# Ansys Electronics Desktop project, version 2020.1
materials:
  vacuum: permittivity=1

design HFSSDesign1 (HFSS, DrivenModal, model units mm)
geometry:
  SimulationModels_Unnamed_1 [vacuum] = imported_body(C:\Users\cos\Desktop\IVEC2024\SinglePoint\SimulationModels.sat)
  SimulationModels_Unnamed_2..SimulationModels_Unnamed_5 = imported_body(C:\Users\cos\Desktop\IVEC2024\SinglePoint\SimulationModels.sat)
  group SimulationModels = SimulationModels_Unnamed_1..SimulationModels_Unnamed_5
boundaries and excitations:
  1: Wave Port Objects=SimulationModels_Unnamed_2 NumModes=1 Modes{Mode1{IntLine{middle of ?.edge(#1062) -> middle of ?.edge(#1060)} CharImp=Zpv}}
  2: Wave Port Objects=SimulationModels_Unnamed_4 NumModes=1 Modes{Mode1{IntLine{middle of ?.edge(#1083) -> middle of ?.edge(#1085)} CharImp=Zpv}}
  3: Wave Port Objects=SimulationModels_Unnamed_3 NumModes=1 Modes{Mode1{IntLine{middle of ?.edge(#1073) -> middle of ?.edge(#1071)} CharImp=Zpv}}
  4: Wave Port Objects=SimulationModels_Unnamed_5 NumModes=1 Modes{Mode1{IntLine{middle of ?.edge(#1095) -> middle of ?.edge(#1093)} CharImp=Zpv}}
setups:
  Setup1: HfssDriven Frequency=95GHz MaxDeltaS=0.01 MaximumPasses=6 MinimumPasses=1 MinimumConvergedPasses=1 PercentRefinement=30 BasisOrder=1 Target=0.06 PortAccuracy=2
    sweep Sweep: 90GHz to 100GHz, 101 points; Type=Fast
  Setup2: HfssDriven Frequency=95GHz MaxDeltaS=0.01 MaximumPasses=6 MinimumPasses=1 MinimumConvergedPasses=1 PercentRefinement=30 BasisOrder=0 Target=0.06 PortAccuracy=2
    sweep Sweep: 90GHz to 100GHz, 101 points; Type=Fast
source amplitudes:
  1:1: 1W 0deg
  2:1, 3:1, 4:1: 0W 0deg
field plots:
  Mag_E1: E Field on Setup1 : LastAdaptive at Freq=95GHz Phase=0deg
reports:
  S Parameter Plot 1: mag(S(1,1)), mag(S(2,1)), mag(S(3,1)), mag(S(4,1)) vs Freq on Setup1 : Sweep
  S Parameter Plot 2: dB(S(1,1)), dB(S(2,1)), dB(S(3,1)), dB(S(4,1)) vs Freq on Setup1 : Sweep
  S Parameter Plot 3: mag(S(1,1)), mag(S(2,1)) vs Freq on Setup2 : Sweep
